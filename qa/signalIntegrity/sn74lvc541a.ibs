| TEXAS INSTRUMENTS INCORPORATED
| Standard Linear and Logic Group
| IBIS Model of SN74LVC541A
| OCTAL BUFFERS/DRIVERS WITH 3-STATE OUTPUTS
| This file contains package information for the following:
|  SSOP 20-pin (DB) package as [Component] LVC541A_DB
|  TVSOP 20-pin (DGV) package as [Component] LVC541A_DGV
|  SOIC 20-pin (DW) package as [Component] LVC541A_DW
|  SOP 20-pin (NS) package as [Component] LVC541A_NS
|  QFN 20-pin (RGY) package as [Component] LVC541A_RGY
|  TSSOP 20-pin (PW) package as [Component] LVC541A_PW
| This device can be powered at the following Vccs:
|  1.8 volt Vcc
|  2.5 volt Vcc
|  3.3 volt Vcc
| This file provides unique models under the [Model Selector] for each Vcc.
| For operation at a specific Vcc, select the appropriate model after each
| [Model Selector] keyword.
[IBIS Ver]   3.2
[Comment char]  |_char
[File Name]   sn74lvc541a.ibs
[File Rev]   1.1 | e_die
[Date]   April 15, 2004
[Source]   Data created from TI-SPICE simulations at TI-SLL.
[Notes]   The following is an IBIS list for the LVC541A.
   Please contact sllibis@ti.com with questions and
   comments concerning SLL IBIS models.
   This IBIS model is created from a BA (back annotated netlist)
   - FILE REV HISTORY
   - 1.1 Release IBIS file on 04/15/04
   - Power clamp data deleted as there is no power-clamp diode.
   - Due to the fact that the Device is 5-V Input/Output
   tolarent, the output model has some Non-Monotonic Warnings.
   - 1.2 Release IBIS file on 5/21/20
   - Added 20-pin TSSOP package (PW)
[Disclaimer] Property of Texas Instruments Incorporated.  Unauthorized
                reproduction and/or distribution is strictly prohibited.
                This product is protected under copyright law.
                Created  2004, (C) Copyright  2004, Texas Instruments
                Incorporated, All Rights Reserved
                UNLESS THERE IS A SIGNED, WRITTEN AGREEMENT TO THE
                CONTRARY, TEXAS INSTRUMENTS (TI) IS PROVIDING THE IBIS
                MODELS  AND WITHOUT ANY WARRANTY, EXPRESSED OR
                IMPLIED.  TI assumes no liability for:
                 1) the accuracy of the IBIS models provided to your
                    company;
                 2) the proper functioning of these IBIS Models in your
                    design or for any resulting applications; or
                 3) infringement of patents, copyrights or intellectual
                    property rights resulting from your use of these IBIS
                    models.
                TI provides IBIS Models as a service to our customers.
                You and your company shall not distribute, sell or give
                these models to anyone else without prior written
                permission from TI.
                TI reserves the right to make changes to our products or
                to discontinue any semiconductor product or service
                without notice, and advises our customers to obtain the
                latest version of relevant information to verify, before
                placing orders, that the information being relied on is
                current.
                Please be aware that your receipt and use of the IBIS
                information provided shall serve as acceptance of these
                terms and conditions.  If you do not accept these terms,
                you should return or destroy the IBIS models and any
                other accompanying information immediately.
| Component LVC541A_DB 20-pin SSOP
[Component]   LVC541A_DB
[Manufacturer]   Texas Instruments, Inc.
[Package]
|   typ   min   max
R_pkg   4.000e-02   3.500e-02   5.100e-02
L_pkg   3.495e-09   3.035e-09   4.314e-09
C_pkg   4.200e-13   3.460e-13   5.020e-13
[Pin]   signal_name   model_name   R_pin   L_pin   C_pin
1   NOE1   LVC541A_NOE   4.900e-02   4.310e-09   5.020e-13
2   A1   LVC541A_IN   4.800e-02   3.903e-09   4.870e-13
3   A2   LVC541A_IN   3.500e-02   3.189e-09   3.960e-13
4   A3   LVC541A_IN   3.500e-02   3.036e-09   3.470e-13
5   A4   LVC541A_IN   3.500e-02   3.035e-09   3.670e-13
6   A5   LVC541A_IN   3.500e-02   3.035e-09   3.670e-13
7   A6   LVC541A_IN   3.500e-02   3.036e-09   3.470e-13
8   A7   LVC541A_IN   3.500e-02   3.189e-09   3.970e-13
9   A8   LVC541A_IN   4.700e-02   3.899e-09   4.880e-13
10   GND   GND   5.100e-02   4.314e-09   5.000e-13
11   Y8   LVC541A_OUT   5.100e-02   4.314e-09   5.000e-13
12   Y7   LVC541A_OUT   4.700e-02   3.899e-09   4.880e-13
13   Y6   LVC541A_OUT   3.500e-02   3.189e-09   3.970e-13
14   Y5   LVC541A_OUT   3.500e-02   3.036e-09   3.460e-13
15   Y4   LVC541A_OUT   3.500e-02   3.035e-09   3.670e-13
16   Y3   LVC541A_OUT   3.500e-02   3.035e-09   3.670e-13
17   Y2   LVC541A_OUT   3.500e-02   3.036e-09   3.460e-13
18   Y1   LVC541A_OUT   3.500e-02   3.189e-09   3.970e-13
19   NOE2   LVC541A_NOE   4.700e-02   3.899e-09   4.880e-13
20   VCC   POWER   5.100e-02   4.314e-09   5.020e-13
| Component LVC541A_DGV 20-pin TVSOP
[Component]   LVC541A_DGV
[Manufacturer]   Texas Instruments, Inc.
[Package]
|   typ   min   max
R_pkg   4.400e-02   3.800e-02   4.800e-02
L_pkg   2.561e-09   2.236e-09   2.961e-09
C_pkg   3.420e-13   2.640e-13   4.460e-13
[Pin]   signal_name   model_name   R_pin   L_pin   C_pin
1   NOE1   LVC541A_NOE   4.400e-02   2.935e-09   4.170e-13
2   A1   LVC541A_IN   4.200e-02   2.869e-09   4.460e-13
3   A2   LVC541A_IN   4.300e-02   2.399e-09   3.160e-13
4   A3   LVC541A_IN   4.400e-02   2.236e-09   2.650e-13
5   A4   LVC541A_IN   4.600e-02   2.278e-09   2.640e-13
6   A5   LVC541A_IN   4.500e-02   2.274e-09   2.640e-13
7   A6   LVC541A_IN   4.400e-02   2.285e-09   2.690e-13
8   A7   LVC541A_IN   4.300e-02   2.452e-09   3.200e-13
9   A8   LVC541A_IN   4.400e-02   2.900e-09   4.460e-13
10   GND   GND   4.400e-02   2.961e-09   4.180e-13
11   Y8   LVC541A_OUT   4.500e-02   2.954e-09   4.180e-13
12   Y7   LVC541A_OUT   4.200e-02   2.847e-09   4.430e-13
13   Y6   LVC541A_OUT   4.500e-02   2.453e-09   3.190e-13
14   Y5   LVC541A_OUT   4.500e-02   2.297e-09   2.690e-13
15   Y4   LVC541A_OUT   4.800e-02   2.334e-09   2.680e-13
16   Y3   LVC541A_OUT   4.800e-02   2.335e-09   2.670e-13
17   Y2   LVC541A_OUT   4.600e-02   2.299e-09   2.680e-13
18   Y1   LVC541A_OUT   4.600e-02   2.457e-09   3.200e-13
19   NOE2   LVC541A_NOE   4.300e-02   2.848e-09   4.410e-13
20   VCC   POWER   3.800e-02   2.812e-09   4.080e-13
| Component LVC541A_DW 20-pin SOIC
[Component]   LVC541A_DW
[Manufacturer]   Texas Instruments, Inc.
[Package]
|   typ   min   max
R_pkg   3.800e-02   3.300e-02   4.500e-02
L_pkg   5.012e-09   4.110e-09   6.349e-09
C_pkg   7.170e-13   5.300e-13   8.680e-13
[Pin]   signal_name   model_name   R_pin   L_pin   C_pin
1   NOE1   LVC541A_NOE   4.200e-02   6.336e-09   8.650e-13
2   A1   LVC541A_IN   4.300e-02   5.542e-09   8.670e-13
3   A2   LVC541A_IN   3.400e-02   4.714e-09   7.320e-13
4   A3   LVC541A_IN   3.400e-02   4.377e-09   5.910e-13
5   A4   LVC541A_IN   3.600e-02   4.130e-09   5.330e-13
6   A5   LVC541A_IN   3.500e-02   4.111e-09   5.300e-13
7   A6   LVC541A_IN   3.400e-02   4.284e-09   5.830e-13
8   A7   LVC541A_IN   3.400e-02   4.634e-09   7.260e-13
9   A8   LVC541A_IN   4.000e-02   5.518e-09   8.650e-13
10   GND   GND   4.300e-02   6.349e-09   8.660e-13
11   Y8   LVC541A_OUT   4.100e-02   6.281e-09   8.610e-13
12   Y7   LVC541A_OUT   4.500e-02   5.561e-09   8.680e-13
13   Y6   LVC541A_OUT   3.300e-02   4.778e-09   7.420e-13
14   Y5   LVC541A_OUT   3.500e-02   4.414e-09   5.960e-13
15   Y4   LVC541A_OUT   3.500e-02   4.110e-09   5.330e-13
16   Y3   LVC541A_OUT   3.600e-02   4.130e-09   5.330e-13
17   Y2   LVC541A_OUT   3.400e-02   4.377e-09   5.910e-13
18   Y1   LVC541A_OUT   3.400e-02   4.714e-09   7.310e-13
19   NOE2   LVC541A_NOE   4.300e-02   5.569e-09   8.680e-13
20   VCC   POWER   4.200e-02   6.308e-09   8.640e-13
| Component LVC541A_NS 20-pin SOP
[Component]   LVC541A_NS
[Manufacturer]   Texas Instruments, Inc.
[Package]
|   typ   min   max
R_pkg   4.400e-02   2.900e-02   5.800e-02
L_pkg   3.666e-09   2.317e-09   5.115e-09
C_pkg   5.480e-13   3.160e-13   7.250e-13
[Pin]   signal_name   model_name   R_pin   L_pin   C_pin
1   NOE1   LVC541A_NOE   5.800e-02   5.115e-09   7.250e-13
2   A1   LVC541A_IN   5.300e-02   4.591e-09   7.240e-13
3   A2   LVC541A_IN   4.900e-02   3.754e-09   5.720e-13
4   A3   LVC541A_IN   2.900e-02   2.549e-09   3.880e-13
5   A4   LVC541A_IN   3.100e-02   2.317e-09   3.160e-13
6   A5   LVC541A_IN   3.100e-02   2.317e-09   3.160e-13
7   A6   LVC541A_IN   2.900e-02   2.556e-09   3.990e-13
8   A7   LVC541A_IN   4.900e-02   3.754e-09   5.790e-13
9   A8   LVC541A_IN   5.300e-02   4.591e-09   7.240e-13
10   GND   GND   5.800e-02   5.115e-09   7.250e-13
11   Y8   LVC541A_OUT   5.800e-02   5.115e-09   7.250e-13
12   Y7   LVC541A_OUT   5.300e-02   4.591e-09   7.240e-13
13   Y6   LVC541A_OUT   4.900e-02   3.754e-09   5.790e-13
14   Y5   LVC541A_OUT   2.900e-02   2.557e-09   3.990e-13
15   Y4   LVC541A_OUT   3.100e-02   2.317e-09   3.160e-13
16   Y3   LVC541A_OUT   3.100e-02   2.317e-09   3.160e-13
17   Y2   LVC541A_OUT   2.900e-02   2.557e-09   3.990e-13
18   Y1   LVC541A_OUT   4.900e-02   3.754e-09   5.790e-13
19   NOE2   LVC541A_NOE   5.300e-02   4.591e-09   7.240e-13
20   VCC   POWER   5.800e-02   5.115e-09   7.250e-13
| Component LVC541A_RGY 20-pin QFN
[Component]   LVC541A_RGY
[Manufacturer]   Texas Instruments, Inc.
[Package]
|   typ   min   max
R_pkg   4.600e-02   3.500e-02   5.800e-02
L_pkg   1.036e-09   7.930e-10   1.295e-09
C_pkg   3.410e-13   3.300e-13   3.540e-13
[Pin]   signal_name   model_name   R_pin   L_pin   C_pin
1   NOE1   LVC541A_NOE   5.300e-02   1.181e-09   3.330e-13
2   A1   LVC541A_IN   5.800e-02   1.285e-09   3.520e-13
3   A2   LVC541A_IN   4.600e-02   1.020e-09   3.420e-13
4   A3   LVC541A_IN   3.900e-02   8.780e-10   3.300e-13
5   A4   LVC541A_IN   3.500e-02   7.950e-10   3.340e-13
6   A5   LVC541A_IN   3.500e-02   7.930e-10   3.340e-13
7   A6   LVC541A_IN   3.900e-02   8.730e-10   3.300e-13
8   A7   LVC541A_IN   4.500e-02   1.014e-09   3.420e-13
9   A8   LVC541A_IN   5.800e-02   1.285e-09   3.520e-13
10   GND   GND   5.600e-02   1.244e-09   3.490e-13
11   Y8   LVC541A_OUT   5.300e-02   1.179e-09   3.450e-13
12   Y7   LVC541A_OUT   5.800e-02   1.295e-09   3.520e-13
13   Y6   LVC541A_OUT   4.700e-02   1.038e-09   3.440e-13
14   Y5   LVC541A_OUT   4.000e-02   8.880e-10   3.330e-13
15   Y4   LVC541A_OUT   3.500e-02   7.980e-10   3.380e-13
16   Y3   LVC541A_OUT   3.500e-02   7.940e-10   3.370e-13
17   Y2   LVC541A_OUT   3.900e-02   8.800e-10   3.310e-13
18   Y1   LVC541A_OUT   4.600e-02   1.027e-09   3.430e-13
19   NOE2   LVC541A_NOE   5.800e-02   1.295e-09   3.540e-13
20   VCC   POWER   5.200e-02   1.169e-09   3.340e-13
| Component LVC541A_PW 20-pin TSSOP
[Component]   LVC541A_PW
[Manufacturer]   Texas Instruments, Inc.
[Package]
|   typ   min   max
R_pkg   5.000e-02   4.200e-02   6.000e-02
L_pkg   2.802e-09   2.248e-09   3.553e-09
C_pkg   3.170e-13   2.020e-13   4.430e-13
[Pin]   signal_name   model_name   R_pin   L_pin   C_pin
1   NOE1   LVC541A_NOE   5.500e-02   3.461e-09   4.400e-13
2   A1   LVC541A_IN   5.500e-02   3.150e-09   4.010e-13
3   A2   LVC541A_IN   4.200e-02   2.619e-09   3.020e-13
4   A3   LVC541A_IN   4.500e-02   2.273e-09   2.020e-13
5   A4   LVC541A_IN   4.500e-02   2.248e-09   2.240e-13
6   A5   LVC541A_IN   4.500e-02   2.273e-09   2.260e-13
7   A6   LVC541A_IN   4.400e-02   2.323e-09   2.050e-13
8   A7   LVC541A_IN   4.600e-02   2.704e-09   3.070e-13
9   A8   LVC541A_IN   6.000e-02   3.265e-09   4.110e-13
10   GND   GND   5.700e-02   3.506e-09   4.360e-13
11   Y8   LVC541A_OUT   5.800e-02   3.553e-09   4.370e-13
12   Y7   LVC541A_OUT   5.800e-02   3.193e-09   4.050e-13
13   Y6   LVC541A_OUT   4.200e-02   2.704e-09   3.110e-13
14   Y5   LVC541A_OUT   4.600e-02   2.392e-09   2.100e-13
15   Y4   LVC541A_OUT   4.700e-02   2.334e-09   2.290e-13
16   Y3   LVC541A_OUT   4.700e-02   2.300e-09   2.270e-13
17   Y2   LVC541A_OUT   4.700e-02   2.349e-09   2.070e-13
18   Y1   LVC541A_OUT   4.500e-02   2.677e-09   3.060e-13
19   NOE2   LVC541A_NOE   6.000e-02   3.235e-09   4.060e-13
20   VCC   POWER   5.600e-02   3.487e-09   4.430e-13
| Model LVC541A_NOE
[Model Selector]   LVC541A_NOE
LVC541A_NOE_18   1.8 volt Vcc
LVC541A_NOE_25   2.5 volt Vcc
LVC541A_NOE_33   3.3 volt Vcc
| Model LVC541A_IN
[Model Selector]   LVC541A_IN
LVC541A_IN_18   1.8 volt Vcc
LVC541A_IN_25   2.5 volt Vcc
LVC541A_IN_33   3.3 volt Vcc
| Model LVC541A_OUT
[Model Selector]   LVC541A_OUT
LVC541A_OUT_18   1.8 volt Vcc
LVC541A_OUT_25   2.5 volt Vcc
LVC541A_OUT_33   3.3 volt Vcc
| Models and submodels in the file (9): LVC541A_NOE_18 (Input), LVC541A_NOE_25 (Input), LVC541A_NOE_33 (Input), LVC541A_IN_18 (Input), LVC541A_IN_25 (Input), LVC541A_IN_33 (Input), LVC541A_OUT_18 (3-state), LVC541A_OUT_25 (3-state), LVC541A_OUT_33 (3-state)
